* Big Muff Pi V3 Tone Wicker macro reference.
*
* The physical EHX pedal has independent Wicker and Tone Bypass switches.
* Greybound exposes them as one deliberate macro: it opens C2/C6/C9 and
* bypasses the passive tone stack. The 47 pF values represent the bounded 10%
* companion residual used by the runtime solver, not switch capacitance.

.param V9=9 SUSTAIN=1 VINPK=40m FREQ=3k
.param RSUS_TOP={max(100k*(1-SUSTAIN),1)} RSUS_BOTTOM={max(100k*SUSTAIN,1)}

V9 vcc 0 DC {V9}
VIN input 0 SIN(0 {VINPK} {FREQ})
RSOURCE input input_rs 10k

R1 input_rs q1_in 39k
C1 q1_in q1_b 1u
R2 q1_b 0 47k
R3 q1_c q1_b 470k
* 10% residual equals the bounded Rust Wicker companion conductance.
C2 q1_c q1_b 47p
R4 vcc q1_c 10k
R5 q1_e 0 100
Q1 q1_c q1_b q1_e QBC239

C3 q1_c sustain_top 1u
RSUSTAIN_TOP sustain_top sustain_wiper {RSUS_TOP}
RSUSTAIN_BOTTOM sustain_wiper sustain_bottom {RSUS_BOTTOM}
R6 sustain_bottom 0 1k

C4 sustain_wiper q2_drive 100n
R7 q2_drive q2_b 10k
R8 q2_b 0 100k
R9 q2_c q2_b 470k
C5 q2_b q2_diode 1u
D1 q2_diode q2_c D1N914
D2 q2_c q2_diode D1N914
C6 q2_c q2_b 47p
R10 vcc q2_c 10k
R11 q2_e 0 150
Q2 q2_c q2_b q2_e QBC239

C7 q2_c q3_drive 100n
R12 q3_drive q3_b 10k
R13 q3_b 0 100k
R14 q3_c q3_b 470k
C8 q3_b q3_diode 1u
D3 q3_diode q3_c D1N914
D4 q3_c q3_diode D1N914
C9 q3_c q3_b 47p
R15 vcc q3_c 10k
R16 q3_e 0 150
Q3 q3_c q3_b q3_e QBC239

* Macro bypass: Q3 now drives Q4 directly through C12.
C12 q3_c q4_b 100n
R19 q4_c q4_b 470k
R20 q4_b 0 100k
R21 vcc q4_c 15k
R22 q4_e 0 3.3k
Q4 q4_c q4_b q4_e QBC239
C13 q4_c volume_top 100n
RVOLUME_TOP volume_top output 1
RVOLUME_BOTTOM output 0 100k
RLOAD output 0 1Meg

.model QBC239 NPN(Is=1e-14 Bf=300 Vaf=100 Ikf=100m Cje=15p Cjc=5p Tf=500p Tr=50n)
.model D1N914 D(Is=2.52n N=1.752 Rs=0.568 Cjo=4p M=0.333 Eg=1.11 Bv=100 Ibv=100u Tt=20n)

.control
set filetype=ascii
alterparam FREQ=1k
reset
tran 1u 120m 0 1u
wrdata /tmp/greybound_muffin_v3_wicker_1k_tran.dat v(input_rs) v(q1_c) v(sustain_wiper) v(q2_c) v(q3_c) v(q3_c) v(q4_c) v(output)
alterparam FREQ=3k
reset
tran 1u 80m 0 1u
wrdata /tmp/greybound_muffin_v3_wicker_3k_tran.dat v(input_rs) v(q1_c) v(sustain_wiper) v(q2_c) v(q3_c) v(q3_c) v(q4_c) v(output)
alterparam FREQ=6k
reset
tran 1u 80m 0 1u
wrdata /tmp/greybound_muffin_v3_wicker_6k_tran.dat v(input_rs) v(q1_c) v(sustain_wiper) v(q2_c) v(q3_c) v(q3_c) v(q4_c) v(output)
quit
.endc

.end
